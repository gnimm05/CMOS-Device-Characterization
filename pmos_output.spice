* PMOS Output Characteristics (Id-Vds) - Sky130
.param mc_mm_switch=0
.param mc_pr_switch=0
.lib "/home/gnimm05/pdks/ciel/sky130/versions/0fe599b2afb6708d281543108caf8310912f54af/sky130A/libs.tech/ngspice/sky130.lib.spice" tt

* PMOS DUT: L=0.15 W=1.0 (Nodes: Drain Gate Source Body)
XM1 D G 0 0 sky130_fd_pr__pfet_01v8 L=0.15 W=1.0

* Voltage Sources
VDS D 0 0V
VGS G 0 0V

.control
  * Sweep VDS from 0 to -1.8V. Step VGS from -0.6V to -1.8V.
  dc VDS 0 -1.8 -0.01 VGS -0.6 -1.8 -0.3

  let id = I(VDS)
  wrdata pmos_output_data.txt id
.endc
.end
